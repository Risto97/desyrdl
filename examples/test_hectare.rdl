`include "test_hectare.sv"

addrmap test_hectare {
  addressing = regalign; // this is the default

  reg {
    field {sw=rw; hw=r; swmod; } data[31:0];
  } hectare;

  reg {
    field {counter; } count[31:0];
  } hcounter;

  reg {
    field {sw=r; hw=rw; } data[31:0];
  } iitoh;

  external mem {
    memwidth = 32;
    mementries = `C_COOLMEM_ENTRIES;
  } coolmem;
  coolmem->interface = "DPM";

  external spi_ad9510 spi_ad9510_a @0x10000;
  spi_ad9510_a->interface = "AXI4";

  // test_hectare.sv holds size and address information for downstream IBUS
  // modules
  external generic_ibus #(.SIZE(`C_SIZE_LLRF_CTABLES)) llrf_ctables @`C_ADDR_LLRF_CTABLES;

};
