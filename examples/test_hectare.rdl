
addrmap test_hectare {
  reg {
    field {sw=rw; hw=r; swmod; } data[31:0];
  } hectare;

  reg {
    field {counter; } count[31:0];
  } hcounter;

  reg {
    field {sw=r; hw=rw; } data[31:0];
  } iitoh;

  external mem {
    memwidth = 32;
    mementries = 1024;
  } coolmem;
  coolmem->interface = "DPM";

  external spi_ad9510 spi_ad9510_a @0x10000;
  spi_ad9510_a->interface = "AXI4";

  external spi_ad9510 spi_ad9510_b;
  spi_ad9510_b->interface = "IBUS";

};
